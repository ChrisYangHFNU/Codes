# Ansys Electronics Desktop project, version 2021.2
materials:
  vacuum: permittivity=1

design HFSSDesign1 (HFSS, DrivenModal, model units mm)
options: Calculate_Lossy_Dielectrics Save_Adaptive_support_files
variables:
  X1 = 14.6948mm
  Y1 = 5.0898e-16mm
  Z1 = 0mm
  X2 = 23.4393mm
  Y2 = 1.1753mm
  Z2 = 0mm
  X3 = 26.3677mm
  Y3 = 1.3575mm
  Z3 = 0mm
  X4 = 26.3546mm
  Y4 = 1.5671mm
  Z4 = 0mm
  X5 = 23.4262mm
  Y5 = 1.3849mm
  Z5 = 0mm
  X6 = 14.6029mm
  Y6 = 1.4694mm
  Z6 = 0mm
  X7 = 23.136mm
  Y7 = 3.7141mm
  Z7 = 0mm
  X8 = 26.0197mm
  Y8 = 4.2551mm
  Z8 = 0mm
  X9 = 25.981mm
  Y9 = 4.4615mm
  Z9 = 0mm
  X10 = 23.0972mm
  Y10 = 3.9204mm
  Z10 = 0mm
  X11 = 14.3281mm
  Y11 = 2.9271mm
  Z11 = 0mm
  X12 = 22.53mm
  Y12 = 6.1822mm
  Z12 = 0mm
  X13 = 25.3285mm
  Y13 = 7.0635mm
  Z13 = 0mm
  X14 = 25.2654mm
  Y14 = 7.2638mm
  Z14 = 0mm
  X15 = 22.4669mm
  Y15 = 6.3825mm
  Z15 = 0mm
  X16 = 13.874mm
  Y16 = 4.3642mm
  Z16 = 0mm
  X17 = 21.6486mm
  Y17 = 8.5432mm
  Z17 = 0mm
  X18 = 24.3291mm
  Y18 = 9.7364mm
  Z18 = 0mm
  X19 = 24.2437mm
  Y19 = 9.9283mm
  Z19 = 0mm
  X20 = 21.5632mm
  Y20 = 8.7351mm
  Z20 = 0mm
  X21 = 13.2554mm
  Y21 = 5.7538mm
  Z21 = 0mm
  X22 = 19.0563mm
  Y22 = 12.5882mm
  Z22 = 0mm
  X23 = 21.1041mm
  Y23 = 14.6894mm
  Z23 = 0mm
  X24 = 20.9537mm
  Y24 = 14.836mm
  Z24 = 0mm
  X25 = 18.9059mm
  Y25 = 12.7348mm
  Z25 = 0mm
  X26 = 12.4198mm
  Y26 = 6.9618mm
  Z26 = 0mm
  X27 = 17.8403mm
  Y27 = 14.0897mm
  Z27 = 0mm
  X28 = 19.7731mm
  Y28 = 16.2972mm
  Z28 = 0mm
  X29 = 19.6152mm
  Y29 = 16.4355mm
  Z29 = 0mm
  X30 = 17.6823mm
  Y30 = 14.2281mm
  Z30 = 0mm
  X31 = 11.5056mm
  Y31 = 8.1113mm
  Z31 = 0mm
  X32 = 16.0482mm
  Y32 = 15.8058mm
  Z32 = 0mm
  X33 = 17.7132mm
  Y33 = 18.2217mm
  Z33 = 0mm
  X34 = 17.5403mm
  Y34 = 18.3409mm
  Z34 = 0mm
  X35 = 15.8753mm
  Y35 = 15.9249mm
  Z35 = 0mm
  X36 = 10.428mm
  Y36 = 9.1239mm
  Z36 = 0mm
  X37 = 13.3847mm
  Y37 = 17.5186mm
  Z37 = 0mm
  X38 = 14.5531mm
  Y38 = 20.21mm
  Z38 = 0mm
  X39 = 14.3604mm
  Y39 = 20.2936mm
  Z39 = 0mm
  X40 = 13.1921mm
  Y40 = 17.6022mm
  Z40 = 0mm
  X41 = 9.1388mm
  Y41 = 9.8484mm
  Z41 = 0mm
  X42 = 9.1854mm
  Y42 = 18.6938mm
  Z42 = 0mm
  X43 = 9.4291mm
  Y43 = 21.6177mm
  Z43 = 0mm
  X44 = 9.2199mm
  Y44 = 21.6351mm
  Z44 = 0mm
  X45 = 8.9761mm
  Y45 = 18.7112mm
  Z45 = 0mm
  X46 = 7.5605mm
  Y46 = 10.013mm
  Z46 = 0mm
  X47 = 4.3758mm
  Y47 = 18.1854mm
  Z47 = 0mm
  X48 = 3.5276mm
  Y48 = 20.9942mm
  Z48 = 0mm
  X49 = 3.3266mm
  Y49 = 20.9335mm
  Z49 = 0mm
  X50 = 4.1748mm
  Y50 = 18.1247mm
  Z50 = 0mm
  X51 = 6.0791mm
  Y51 = 9.4443mm
  Z51 = 0mm
  X52 = 0.99176mm
  Y52 = 16.5285mm
  Z52 = 0mm
  X53 = -0.53241mm
  Y53 = 19.0356mm
  Z53 = 0mm
  X54 = -0.71185mm
  Y54 = 18.9265mm
  Z54 = 0mm
  X55 = 0.81232mm
  Y55 = 16.4194mm
  Z55 = 0mm
  X56 = 4.87mm
  Y56 = 8.4609mm
  Z56 = 0mm
  X57 = -1.6373mm
  Y57 = 14.202mm
  Z57 = 0mm
  X58 = -3.6835mm
  Y58 = 16.3048mm
  Z58 = 0mm
  X59 = -3.834mm
  Y59 = 16.1584mm
  Z59 = 0mm
  X60 = -1.7878mm
  Y60 = 14.0556mm
  Z60 = 0mm
  X61 = 3.9821mm
  Y61 = 7.1799mm
  Z61 = 0mm
  X62 = -4.3345mm
  Y62 = 11.0937mm
  Z62 = 0mm
  X63 = -6.8755mm
  Y63 = 12.5607mm
  Z63 = 0mm
  X64 = -6.9805mm
  Y64 = 12.3789mm
  Z64 = 0mm
  X65 = -4.4395mm
  Y65 = 10.9118mm
  Z65 = 0mm
  X66 = 2.4898mm
  Y66 = 6.0234mm
  Z66 = 0mm
  X67 = -6.2005mm
  Y67 = 8.7586mm
  Z67 = 0mm
  X68 = -8.9112mm
  Y68 = 9.8815mm
  Z68 = 0mm
  X69 = -8.9916mm
  Y69 = 9.6874mm
  Z69 = 0mm
  X70 = -6.2809mm
  Y70 = 8.5646mm
  Z70 = 0mm
  X71 = 1.2877mm
  Y71 = 4.5544mm
  Z71 = 0mm
  X72 = -7.6111mm
  Y72 = 6.079mm
  Z72 = 0mm
  X73 = -10.4452mm
  Y73 = 6.8384mm
  Z73 = 0mm
  X74 = -10.4996mm
  Y74 = 6.6356mm
  Z74 = 0mm
  X75 = -7.6655mm
  Y75 = 5.8762mm
  Z75 = 0mm
  X76 = 0.44023mm
  Y76 = 2.8374mm
  Z76 = 0mm
  X77 = -8.4936mm
  Y77 = 3.1555mm
  Z77 = 0mm
  X78 = -11.4026mm
  Y78 = 3.5385mm
  Z78 = 0mm
  X79 = -11.43mm
  Y79 = 3.3303mm
  Z79 = 0mm
  X80 = -8.521mm
  Y80 = 2.9473mm
  Z80 = 0mm
  X81 = 0.0022663mm
  Y81 = 0.96365mm
  Z81 = 0mm
  X82 = -8.8022mm
  Y82 = 0.105mm
  Z82 = 0mm
  X83 = -11.7363mm
  Y83 = 0.105mm
  Z83 = 0mm
geometry:
  Polyline1 = polyline((X1, Y1, Z1) (X2, Y2, Z2) (X3, Y3, Z3) (X4, Y4, Z4) (X5, Y5, Z5) (X6, Y6, Z6) (X7, Y7, Z7) (X8, Y8, Z8) (X9, Y9, Z9) (X10, Y10, Z10) (X11, Y11, Z11) (X12, Y12, Z12) (X13, Y13, Z13) (X14, Y14, Z14) (X15, Y15, Z15) (X16, Y16, Z16) (X17, Y17, Z17) (X18, Y18, Z18) (X19, Y19, Z19) (X20, Y20, Z20) (X21, Y21, Z21) (X22, Y22, Z22) (X23, Y23, Z23) (X24, Y24, Z24) (X25, Y25, Z25) (X26, Y26, Z26) (X27, Y27, Z27) (X28, Y28, Z28) (X29, Y29, Z29) (X30, Y30, Z30) (X31, Y31, Z31) (X32, Y32, Z32) (X33, Y33, Z33) (X34, Y34, Z34) (X35, Y35, Z35) (X36, Y36, Z36) (X37, Y37, Z37) (X38, Y38, Z38) (X39, Y39, Z39) (X40, Y40, Z40) (X41, Y41, Z41) (X42, Y42, Z42) (X43, Y43, Z43) (X44, Y44, Z44) (X45, Y45, Z45) (X46, Y46, Z46) (X47, Y47, Z47) (X48, Y48, Z48) (X49, Y49, Z49) (X50, Y50, Z50) (X51, Y51, Z51) (X52, Y52, Z52) (X53, Y53, Z53) (X54, Y54, Z54) (X55, Y55, Z55) (X56, Y56, Z56) (X57, Y57, Z57) (X58, Y58, Z58) (X59, Y59, Z59) (X60, Y60, Z60) (X61, Y61, Z61) (X62, Y62, Z62) (X63, Y63, Z63) (X64, Y64, Z64) (X65, Y65, Z65) (X66, Y66, Z66) (X67, Y67, Z67) (X68, Y68, Z68) (X69, Y69, Z69) (X70, Y70, Z70) (X71, Y71, Z71) (X72, Y72, Z72) (X73, Y73, Z73) (X74, Y74, Z74) (X75, Y75, Z75) (X76, Y76, Z76) (X77, Y77, Z77) (X78, Y78, Z78) (X79, Y79, Z79) (X80, Y80, Z80) (X81, Y81, Z81) (X82, Y82, Z82) (X83, Y83, Z83) (X83, -Y83, Z83) (X82, -Y82, Z82) (X81, -Y81, Z81) (X80, -Y80, Z80) (X79, -Y79, Z79) (X78, -Y78, Z78) (X77, -Y77, Z77) (X76, -Y76, Z76) (X75, -Y75, Z75) (X74, -Y74, Z74) (X73, -Y73, Z73) (X72, -Y72, Z72) (X71, -Y71, Z71) (X70, -Y70, Z70) (X69, -Y69, Z69) (X68, -Y68, Z68) (X67, -Y67, Z67) (X66, -Y66, Z66) (X65, -Y65, Z65) (X64, -Y64, Z64) (X63, -Y63, Z63) (X62, -Y62, Z62) (X61, -Y61, Z61) (X60, -Y60, Z60) (X59, -Y59, Z59) (X58, -Y58, Z58) (X57, -Y57, Z57) (X56, -Y56, Z56) (X55, -Y55, Z55) (X54, -Y54, Z54) (X53, -Y53, Z53) (X52, -Y52, Z52) (X51, -Y51, Z51) (X50, -Y50, Z50) (X49, -Y49, Z49) (X48, -Y48, Z48) (X47, -Y47, Z47) (X46, -Y46, Z46) (X45, -Y45, Z45) (X44, -Y44, Z44) (X43, -Y43, Z43) (X42, -Y42, Z42) (X41, -Y41, Z41) (X40, -Y40, Z40) (X39, -Y39, Z39) (X38, -Y38, Z38) (X37, -Y37, Z37) (X36, -Y36, Z36) (X35, -Y35, Z35) (X34, -Y34, Z34) (X33, -Y33, Z33) (X32, -Y32, Z32) (X31, -Y31, Z31) (X30, -Y30, Z30) (X29, -Y29, Z29) (X28, -Y28, Z28) (X27, -Y27, Z27) (X26, -Y26, Z26) (X25, -Y25, Z25) (X24, -Y24, Z24) (X23, -Y23, Z23) (X22, -Y22, Z22) (X21, -Y21, Z21) (X20, -Y20, Z20) (X19, -Y19, Z19) (X18, -Y18, Z18) (X17, -Y17, Z17) (X16, -Y16, Z16) (X15, -Y15, Z15) (X14, -Y14, Z14) (X13, -Y13, Z13) (X12, -Y12, Z12) (X11, -Y11, Z11) (X10, -Y10, Z10) (X9, -Y9, Z9) (X8, -Y8, Z8) (X7, -Y7, Z7) (X6, -Y6, Z6) (X5, -Y5, Z5) (X4, -Y4, Z4) (X3, -Y3, Z3) (X2, -Y2, Z2) (X1, -Y1, Z1), closed, covered)
