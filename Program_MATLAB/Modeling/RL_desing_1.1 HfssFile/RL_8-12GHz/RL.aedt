# Ansys Electronics Desktop project, version 2021.2
materials:
  vacuum: permittivity=1

design HFSSDesign1 (HFSS, DrivenModal, model units mm)
options: Calculate_Lossy_Dielectrics Save_Adaptive_support_files
variables:
  X1 = 88.1685mm
  Y1 = 0mm
  Z1 = 0mm
  X2 = 140.603mm
  Y2 = 7.5757mm
  Z2 = 0mm
  X3 = 158.1734mm
  Y3 = 8.6693mm
  Z3 = 0mm
  X4 = 158.1604mm
  Y4 = 8.8789mm
  Z4 = 0mm
  X5 = 140.59mm
  Y5 = 7.7853mm
  Z5 = 0mm
  X6 = 87.6175mm
  Y6 = 8.8164mm
  Z6 = 0mm
  X7 = 138.7189mm
  Y7 = 22.8003mm
  Z7 = 0mm
  X8 = 156.0214mm
  Y8 = 26.0469mm
  Z8 = 0mm
  X9 = 155.9827mm
  Y9 = 26.2533mm
  Z9 = 0mm
  X10 = 138.6802mm
  Y10 = 23.0067mm
  Z10 = 0mm
  X11 = 85.9687mm
  Y11 = 17.5626mm
  Z11 = 0mm
  X12 = 135.0221mm
  Y12 = 37.5937mm
  Z12 = 0mm
  X13 = 151.8135mm
  Y13 = 42.882mm
  Z13 = 0mm
  X14 = 151.7504mm
  Y14 = 43.0823mm
  Z14 = 0mm
  X15 = 134.959mm
  Y15 = 37.794mm
  Z15 = 0mm
  X16 = 83.2438mm
  Y16 = 26.1849mm
  Z16 = 0mm
  X17 = 129.6781mm
  Y17 = 51.7389mm
  Z17 = 0mm
  X18 = 145.761mm
  Y18 = 58.8981mm
  Z18 = 0mm
  X19 = 145.6756mm
  Y19 = 59.09mm
  Z19 = 0mm
  X20 = 129.5927mm
  Y20 = 51.9308mm
  Z20 = 0mm
  X21 = 79.5322mm
  Y21 = 34.5229mm
  Z21 = 0mm
  X22 = 113.9617mm
  Y22 = 75.8956mm
  Z22 = 0mm
  X23 = 126.2487mm
  Y23 = 88.503mm
  Z23 = 0mm
  X24 = 126.0983mm
  Y24 = 88.6495mm
  Z24 = 0mm
  X25 = 113.8113mm
  Y25 = 76.0422mm
  Z25 = 0mm
  X26 = 74.519mm
  Y26 = 41.7706mm
  Z26 = 0mm
  X27 = 106.6468mm
  Y27 = 84.8842mm
  Z27 = 0mm
  X28 = 118.2439mm
  Y28 = 98.129mm
  Z28 = 0mm
  X29 = 118.0859mm
  Y29 = 98.2673mm
  Z29 = 0mm
  X30 = 106.4888mm
  Y30 = 85.0226mm
  Z30 = 0mm
  X31 = 69.0339mm
  Y31 = 48.668mm
  Z31 = 0mm
  X32 = 95.8569mm
  Y32 = 95.1326mm
  Z32 = 0mm
  X33 = 105.8468mm
  Y33 = 109.6281mm
  Z33 = 0mm
  X34 = 105.6738mm
  Y34 = 109.7472mm
  Z34 = 0mm
  X35 = 95.684mm
  Y35 = 95.2518mm
  Z35 = 0mm
  X36 = 62.5678mm
  Y36 = 54.7437mm
  Z36 = 0mm
  X37 = 79.8268mm
  Y37 = 105.3206mm
  Z37 = 0mm
  X38 = 86.8368mm
  Y38 = 121.4691mm
  Z38 = 0mm
  X39 = 86.6442mm
  Y39 = 121.5528mm
  Z39 = 0mm
  X40 = 79.6341mm
  Y40 = 105.4042mm
  Z40 = 0mm
  X41 = 54.8326mm
  Y41 = 59.0902mm
  Z41 = 0mm
  X42 = 54.5893mm
  Y42 = 112.2061mm
  Z42 = 0mm
  X43 = 56.0516mm
  Y43 = 129.7497mm
  Z43 = 0mm
  X44 = 55.8423mm
  Y44 = 129.7672mm
  Z44 = 0mm
  X45 = 54.38mm
  Y45 = 112.2236mm
  Z45 = 0mm
  X46 = 45.3631mm
  Y46 = 60.0781mm
  Z46 = 0mm
  X47 = 25.7523mm
  Y47 = 108.9606mm
  Z47 = 0mm
  X48 = 20.6632mm
  Y48 = 125.8134mm
  Z48 = 0mm
  X49 = 20.4622mm
  Y49 = 125.7527mm
  Z49 = 0mm
  X50 = 25.5512mm
  Y50 = 108.8999mm
  Z50 = 0mm
  X51 = 36.4748mm
  Y51 = 56.6655mm
  Z51 = 0mm
  X52 = 5.502mm
  Y52 = 98.8981mm
  Z52 = 0mm
  X53 = -3.6431mm
  Y53 = 113.9409mm
  Z53 = 0mm
  X54 = -3.8225mm
  Y54 = 113.8318mm
  Z54 = 0mm
  X55 = 5.3225mm
  Y55 = 98.789mm
  Z55 = 0mm
  X56 = 29.2199mm
  Y56 = 50.7652mm
  Z56 = 0mm
  X57 = -10.2002mm
  Y57 = 84.8461mm
  Z57 = 0mm
  X58 = -22.4775mm
  Y58 = 97.4629mm
  Z58 = 0mm
  X59 = -22.628mm
  Y59 = 97.3165mm
  Z59 = 0mm
  X60 = -10.3507mm
  Y60 = 84.6996mm
  Z60 = 0mm
  X61 = 23.8927mm
  Y61 = 43.0795mm
  Z61 = 0mm
  X62 = -26.2695mm
  Y62 = 66.1075mm
  Z62 = 0mm
  X63 = -41.5153mm
  Y63 = 74.9097mm
  Z63 = 0mm
  X64 = -41.6203mm
  Y64 = 74.7278mm
  Z64 = 0mm
  X65 = -26.3745mm
  Y65 = 65.9256mm
  Z65 = 0mm
  X66 = 14.9386mm
  Y66 = 36.1404mm
  Z66 = 0mm
  X67 = -37.404mm
  Y67 = 52.0668mm
  Z67 = 0mm
  X68 = -53.6683mm
  Y68 = 58.8037mm
  Z68 = 0mm
  X69 = -53.7487mm
  Y69 = 58.6097mm
  Z69 = 0mm
  X70 = -37.4843mm
  Y70 = 51.8728mm
  Z70 = 0mm
  X71 = 7.726mm
  Y71 = 27.3262mm
  Z71 = 0mm
  X72 = -45.8026mm
  Y72 = 35.9669mm
  Z72 = 0mm
  X73 = -62.8071mm
  Y73 = 40.5233mm
  Z73 = 0mm
  X74 = -62.8615mm
  Y74 = 40.3204mm
  Z74 = 0mm
  X75 = -45.8569mm
  Y75 = 35.7641mm
  Z75 = 0mm
  X76 = 2.6414mm
  Y76 = 17.0242mm
  Z76 = 0mm
  X77 = -51.0303mm
  Y77 = 18.4125mm
  Z77 = 0mm
  X78 = -68.4841mm
  Y78 = 20.7103mm
  Z78 = 0mm
  X79 = -68.5115mm
  Y79 = 20.5021mm
  Z79 = 0mm
  X80 = -51.0577mm
  Y80 = 18.2043mm
  Z80 = 0mm
  X81 = 0.013598mm
  Y81 = 5.7819mm
  Z81 = 0mm
  X82 = -52.8133mm
  Y82 = 0.105mm
  Z82 = 0mm
  X83 = -70.4177mm
  Y83 = 0.105mm
  Z83 = 0mm
geometry:
  Polyline1 = polyline((X1, Y1, Z1) (X2, Y2, Z2) (X3, Y3, Z3) (X4, Y4, Z4) (X5, Y5, Z5) (X6, Y6, Z6) (X7, Y7, Z7) (X8, Y8, Z8) (X9, Y9, Z9) (X10, Y10, Z10) (X11, Y11, Z11) (X12, Y12, Z12) (X13, Y13, Z13) (X14, Y14, Z14) (X15, Y15, Z15) (X16, Y16, Z16) (X17, Y17, Z17) (X18, Y18, Z18) (X19, Y19, Z19) (X20, Y20, Z20) (X21, Y21, Z21) (X22, Y22, Z22) (X23, Y23, Z23) (X24, Y24, Z24) (X25, Y25, Z25) (X26, Y26, Z26) (X27, Y27, Z27) (X28, Y28, Z28) (X29, Y29, Z29) (X30, Y30, Z30) (X31, Y31, Z31) (X32, Y32, Z32) (X33, Y33, Z33) (X34, Y34, Z34) (X35, Y35, Z35) (X36, Y36, Z36) (X37, Y37, Z37) (X38, Y38, Z38) (X39, Y39, Z39) (X40, Y40, Z40) (X41, Y41, Z41) (X42, Y42, Z42) (X43, Y43, Z43) (X44, Y44, Z44) (X45, Y45, Z45) (X46, Y46, Z46) (X47, Y47, Z47) (X48, Y48, Z48) (X49, Y49, Z49) (X50, Y50, Z50) (X51, Y51, Z51) (X52, Y52, Z52) (X53, Y53, Z53) (X54, Y54, Z54) (X55, Y55, Z55) (X56, Y56, Z56) (X57, Y57, Z57) (X58, Y58, Z58) (X59, Y59, Z59) (X60, Y60, Z60) (X61, Y61, Z61) (X62, Y62, Z62) (X63, Y63, Z63) (X64, Y64, Z64) (X65, Y65, Z65) (X66, Y66, Z66) (X67, Y67, Z67) (X68, Y68, Z68) (X69, Y69, Z69) (X70, Y70, Z70) (X71, Y71, Z71) (X72, Y72, Z72) (X73, Y73, Z73) (X74, Y74, Z74) (X75, Y75, Z75) (X76, Y76, Z76) (X77, Y77, Z77) (X78, Y78, Z78) (X79, Y79, Z79) (X80, Y80, Z80) (X81, Y81, Z81) (X82, Y82, Z82) (X83, Y83, Z83) (X83, -Y83, Z83) (X82, -Y82, Z82) (X81, -Y81, Z81) (X80, -Y80, Z80) (X79, -Y79, Z79) (X78, -Y78, Z78) (X77, -Y77, Z77) (X76, -Y76, Z76) (X75, -Y75, Z75) (X74, -Y74, Z74) (X73, -Y73, Z73) (X72, -Y72, Z72) (X71, -Y71, Z71) (X70, -Y70, Z70) (X69, -Y69, Z69) (X68, -Y68, Z68) (X67, -Y67, Z67) (X66, -Y66, Z66) (X65, -Y65, Z65) (X64, -Y64, Z64) (X63, -Y63, Z63) (X62, -Y62, Z62) (X61, -Y61, Z61) (X60, -Y60, Z60) (X59, -Y59, Z59) (X58, -Y58, Z58) (X57, -Y57, Z57) (X56, -Y56, Z56) (X55, -Y55, Z55) (X54, -Y54, Z54) (X53, -Y53, Z53) (X52, -Y52, Z52) (X51, -Y51, Z51) (X50, -Y50, Z50) (X49, -Y49, Z49) (X48, -Y48, Z48) (X47, -Y47, Z47) (X46, -Y46, Z46) (X45, -Y45, Z45) (X44, -Y44, Z44) (X43, -Y43, Z43) (X42, -Y42, Z42) (X41, -Y41, Z41) (X40, -Y40, Z40) (X39, -Y39, Z39) (X38, -Y38, Z38) (X37, -Y37, Z37) (X36, -Y36, Z36) (X35, -Y35, Z35) (X34, -Y34, Z34) (X33, -Y33, Z33) (X32, -Y32, Z32) (X31, -Y31, Z31) (X30, -Y30, Z30) (X29, -Y29, Z29) (X28, -Y28, Z28) (X27, -Y27, Z27) (X26, -Y26, Z26) (X25, -Y25, Z25) (X24, -Y24, Z24) (X23, -Y23, Z23) (X22, -Y22, Z22) (X21, -Y21, Z21) (X20, -Y20, Z20) (X19, -Y19, Z19) (X18, -Y18, Z18) (X17, -Y17, Z17) (X16, -Y16, Z16) (X15, -Y15, Z15) (X14, -Y14, Z14) (X13, -Y13, Z13) (X12, -Y12, Z12) (X11, -Y11, Z11) (X10, -Y10, Z10) (X9, -Y9, Z9) (X8, -Y8, Z8) (X7, -Y7, Z7) (X6, -Y6, Z6) (X5, -Y5, Z5) (X4, -Y4, Z4) (X3, -Y3, Z3) (X2, -Y2, Z2) (X1, -Y1, Z1), closed, covered)
